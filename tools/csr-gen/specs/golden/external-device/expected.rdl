// Generated by csr-gen 1.0.0. Do not edit by hand.

property csr_gen_access {
    type = string;
    component = field;
};

addrmap csr_registers {
    desc = "CSR Registers";

    reg {
        regwidth = 32;
        desc = "Device ready flag";
        field { sw = r; hw = r; csr_gen_access = "ro"; desc = "Device ready flag"; } FLAG[0:0] = 0;
    } STATUS @ 0x0;

    external reg {
        regwidth = 32;
        desc = "FIFO payload";
        field { sw = rw; hw = rw; csr_gen_access = "rw"; desc = "FIFO payload"; } DATA[7:0] = 0;
        field { sw = r; hw = r; csr_gen_access = "ro"; desc = "FIFO fill level"; } LEVEL[15:8] = 0;
    } FIFO @ 0x10;

    external reg {
        regwidth = 32;
        desc = "External read/write memory window";
        field { sw = rw; hw = rw; csr_gen_access = "rw"; desc = "External read/write memory window"; } WINDOW[31:0] = 0;
    } MEM[4] @ 0x20 += 0x4;

    external reg {
        regwidth = 32;
        desc = "External read-only memory window";
        field { sw = r; hw = r; csr_gen_access = "ro"; desc = "External read-only memory window"; } IMAGE[31:0] = 0;
    } ROM[4] @ 0x30 += 0x4;

    external reg {
        regwidth = 32;
        desc = "External write-only memory window";
        field { sw = w; hw = r; csr_gen_access = "wo"; desc = "External write-only memory window"; } BUFFER[31:0] = 0;
    } WBUF[4] @ 0x40 += 0x4;

};
