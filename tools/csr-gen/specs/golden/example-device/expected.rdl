// Generated by csr-gen 1.0.0. Do not edit by hand.

property csr_gen_access {
    type = string;
    component = field;
};

addrmap csr_registers {
    desc = "CSR Registers";

    reg {
        regwidth = 32;
        desc = "Control register";
        field { sw = rw; hw = rw; csr_gen_access = "rw"; desc = "Control register"; } ENABLE[0:0] = 0;
        field { sw = rw; hw = rw; csr_gen_access = "rw"; desc = "Enable debug mode"; } MODE[2:1] = 1;
        field { sw = r; hw = r; csr_gen_access = "none"; desc = "Select mode"; } RSVD[31:3] = 0;
    } CTRL @ 0x0;

    reg {
        regwidth = 32;
        desc = "Event register and pending event bits";
        field { sw = rw; hw = rw; csr_gen_access = "rw1c"; onwrite = woclr; desc = "Event register and pending event bits"; } PENDING[7:0] = 0;
    } EVENTS @ 0x4;

};
